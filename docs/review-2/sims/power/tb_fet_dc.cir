AO4485 model sanity: Id vs Vgs at Vds=-5 V
.include models.inc
Vd d 0 -5
Vg g 0 0
M1 d g 0 0 AO4485
.dc Vg 0 -5 -0.05
.meas dc id_1v7 find i(Vd) at=-1.7
.meas dc id_2v0 find i(Vd) at=-2.0
.meas dc id_2v5 find i(Vd) at=-2.5
.meas dc id_3v0 find i(Vd) at=-3.0
.meas dc id_4v5 find i(Vd) at=-4.5
.end
