* lc_core_derated_open: BTL LC filter, L=8e-06 DCR=0.03 C=6e-07 per leg, RL=1000000.0
Vp dp 0 DC 0 AC 0.5
Vn dn 0 DC 0 AC 0.5 180
La dp la 8.000000000000001e-06
Rla la a 0.03
Lb dn lb 8.000000000000001e-06
Rlb lb b 0.03
Ca a ca 6e-07
Rca ca 0 0.005
Cb b cb 6e-07
Rcb cb 0 0.005
Rsa a sa 4.7
Csa sa 0 1e-09
Rsb b sb 4.7
Csb sb 0 1e-09
RL a b 1000000.0
Ed d 0 a b 1
.ac dec 400 100 2Meg
.measure ac hpk MAX vdb(d)
.measure ac f0 WHEN vp(d)=-1.5708
.measure ac h1k FIND vdb(d) AT=1k
.measure ac h20k FIND vdb(d) AT=20k
.measure ac f3 WHEN vdb(d)=-3 FALL=LAST
.measure ac h400k FIND vdb(d) AT=400k
.measure ac h600k FIND vdb(d) AT=600k
.end
